// Design: EE_140_240A_Final_Project/EE_140_240A_Sp25_System
simulator lang=spectre
global 0
parameters _EXPR_8=3e-05 FCLK=1M G_0=1 G_1=1 G_2=1 NBAT=2 S_0=0 S_1=0 TRISE_BAT=100n TR_D=1u VBAT=1.1 VDDA_IDEAL=1.8 VDDD_IDEAL=1.8 VIN_0=12.5m VIN_1=1
include "/home/ff/ee140/fa19/xfab/XKIT/xt018/cadence/v8_0/spectre/v8_0_2/lp5mos/config.scs" section=default
include "/home/ff/ee140/fa19/xfab/XKIT/xt018/cadence/v8_0/spectre/v8_0_2/lp5mos/param.scs" section=3s
include "/home/ff/ee140/fa19/xfab/XKIT/xt018/cadence/v8_0/spectre/v8_0_2/lp5mos/bip.scs" section=tm
include "/home/ff/ee140/fa19/xfab/XKIT/xt018/cadence/v8_0/spectre/v8_0_2/lp5mos/cap.scs" section=tm
include "/home/ff/ee140/fa19/xfab/XKIT/xt018/cadence/v8_0/spectre/v8_0_2/lp5mos/dio.scs" section=tm
include "/home/ff/ee140/fa19/xfab/XKIT/xt018/cadence/v8_0/spectre/v8_0_2/lp5mos/mos.scs" section=tm
include "/home/ff/ee140/fa19/xfab/XKIT/xt018/cadence/v8_0/spectre/v8_0_2/lp5mos/res.scs" section=tm
include "/home/cc/ee140/sp25/staff/ee140-tab/cadence/cadence_finalproj/sky130_release_0.0.4/models/sky130.lib.spice" section=tt

// EE_140_240A_Final_Project/invr_dupe/schematic
subckt invr_dupe in out VDD VSS
parameters GT_PDW GT_PDL=180.00n sx=4.8e-07 lc=2.7e-07 GT_PUW GT_PUL=180.00n
    ne (out in VSS VSS) ne w=GT_PDW l=GT_PDL m=(1)*(1)
    pe (out in VDD VDD) pe w=GT_PUW l=GT_PUL m=(1)*(1)
ends invr_dupe

// final_project_schematics/mux_switches/schematic
subckt mux_switches A B CLK VDD VSS
    PM0 (B \!CLK A VDD) pfet_01v8 w=(1u) l=150n m=(280)*(1)
    NM0 (A CLK B VSS) nfet_01v8 w=(1u) l=150n m=(70)*(1)
    I1 (CLK \!CLK VDD VSS) invr_dupe GT_PDW=420n GT_PDL=180.00n sx=4.8e-07 lc=2.7e-07 GT_PUW=720n GT_PUL=180.00n
ends mux_switches

// EE_140_240A_Final_Project/AND2HDX0_dupe/schematic
subckt AND2HDX0_dupe A B OUT VDD VSS
    ne (OUT net027 VSS VSS) ne w=420.0n l=180.0n m=(1)*(1)
    MN1 (net027 A net029 VSS) ne w=420.0n l=180.0n m=(1)*(1)
    MN2 (net029 B VSS VSS) ne w=420.0n l=180.0n m=(1)*(1)
    pe (OUT net027 VDD VDD) pe w=720.0n l=180.0n m=(1)*(1)
    MP1 (net027 A VDD VDD) pe w=720.0n l=180.0n m=(1)*(1)
    MP2 (net027 B VDD VDD) pe w=720.0n l=180.0n m=(1)*(1)
ends AND2HDX0_dupe

// EE_140_240A_Final_Project/nor2_dupe/schematic
subckt nor2_dupe a b out VDD VSS
parameters GT_PDW GT_PDL=180.00n sx=4.8e-07 lc=2.7e-07 GT_PUW GT_PUL=180.00n
    MN1 (out b VSS VSS) ne w=GT_PDW l=GT_PDL m=(1)*(1)
    MN2 (out a VSS VSS) ne w=GT_PDW l=GT_PDL m=(1)*(1)
    MP1 (out a net14 VDD) pe w=GT_PUW l=GT_PUL m=(1)*(1)
    MP2 (net14 b VDD VDD) pe w=GT_PUW l=GT_PUL m=(1)*(1)
ends nor2_dupe

// EE_140_240A_Final_Project/OR2HDX0_dupe/schematic
subckt OR2HDX0_dupe A B OUT VDD VSS
    I1 (net11 OUT VDD VSS) invr_dupe GT_PDW=420n GT_PDL=180.00n sx=4.8e-07 lc=2.7e-07 GT_PUW=720n GT_PUL=180.00n
    I0 (A B net11 VDD VSS) nor2_dupe GT_PDW=420n GT_PDL=180.00n sx=4.8e-07 lc=2.7e-07 GT_PUW=720n GT_PUL=180.00n
ends OR2HDX0_dupe

// final_project_schematics/2_stage_folded/schematic
subckt final_project_schematics_2_stage_folded_schematic V\+ V\- VDD VOUT VSS
    NM9 (net5 VB3 net32 net32) nfet_01v8 w=(8u) l=450n m=(1)*(1)
    NM8 (net4 VB3 net2 net2) nfet_01v8 w=(8u) l=450n m=(1)*(1)
    NM7 (VOUT VB2 VSS VSS) nfet_01v8 w=(1u) l=450n m=(14)*(1)
    NM2 (net32 VB2 VSS VSS) nfet_01v8 w=(1u) l=450n m=(16)*(1)
    NM0 (net2 VB2 VSS VSS) nfet_01v8 w=(1u) l=450n m=(16)*(1)
    NM5 (VB4 VB2 VSS VSS) nfet_01v8 w=(550n) l=450n m=(8)*(1)
    NM4 (VB3 VB3 VSS VSS) nfet_01v8 w=(800n) l=450n m=(1)*(1)
    NM3 (net1 VB1 VSS VSS) nfet_01v8 w=(420n) l=150n m=(1)*(1)
    NM1 (VB1 VB2 VSS VSS) nfet_01v8 w=(550n) l=450n m=(1)*(1)
    NM11 (VB2 VB2 VSS VSS) nfet_01v8 w=(550n) l=450n m=(1)*(1)
    PM15 (net9 net5 VDD VDD) pfet_01v8 w=(1u) l=450n m=(30)*(1)
    PM14 (net8 net5 VDD VDD) pfet_01v8 w=(1u) l=450n m=(30)*(1)
    PM3 (net1 VB1 VDD VDD) pfet_01v8 w=(550n) l=150n m=(1)*(1)
    PM13 (VOUT net4 VDD VDD) pfet_01v8 w=(1u) l=450n m=(48)*(1)
    PM12 (net4 VB4 net9 net9) pfet_01v8 w=(1u) l=450n m=(30)*(1)
    PM11 (net5 VB4 net8 net8) pfet_01v8 w=(1u) l=450n m=(30)*(1)
    PM5 (VB3 VB1 VDD VDD) pfet_01v8 w=(9.5u) l=450n m=(12)*(1)
    PM10 (net3 VB1 VDD VDD) pfet_01v8 w=(1u) l=450n m=(137)*(1)
    PM9 (net2 V\+ net3 net3) pfet_01v8 w=(32u) l=450n m=(2)*(1)
    PM7 (net32 V\- net3 net3) pfet_01v8 w=(32u) l=450n m=(2)*(1)
    PM6 (VB4 VB4 VDD VDD) pfet_01v8 w=(2.7u) l=450n m=(1)*(1)
    PM1 (VB1 VB1 VDD VDD) pfet_01v8 w=(9.5u) l=450n m=(1)*(1)
    PM0 (VB2 VB1 net6 net6) pfet_01v8 w=(9.5u) l=450n m=(4)*(1)
    PM4 (VB2 net1 VDD VDD) pfet_01v8 w=(550n) l=150n m=(1)*(1)
    R1 (net7 VOUT) resistor r=500
    R0 (VDD net6) resistor r=14K
    C1 (net7 net4) capacitor c=750f
ends final_project_schematics_2_stage_folded_schematic

// EE_140_240A_Final_Project/opamp_mockup/schematic
subckt opamp_mockup VDD VINN VINP VOUT VSS
parameters Rout
    E0 (net8 VSS VINP VINN) vcvs gain=10000 type=vcvs min=0 max=1.8
    R0 (net8 VOUT) resistor r=Rout
ends opamp_mockup

// final_project_schematics/pga_switches/schematic
subckt pga_switches A B CLK VDD VSS
    PM0 (B \!CLK A VDD) pfet_01v8 w=(550n) l=150n m=(1)*(1)
    NM0 (A CLK B VSS) nfet_01v8 w=(420n) l=150n m=(1)*(1)
    I1 (CLK \!CLK VDD VSS) invr_dupe GT_PDW=420n GT_PDL=180.00n sx=4.8e-07 lc=2.7e-07 GT_PUW=720n GT_PUL=180.00n
ends pga_switches

// EE_140_240A_Final_Project/PGA_mockup/schematic
subckt PGA_mockup CLK1 CLK2 G\<2\> G\<1\> G\<0\> VDD VIN VOUT VSS
parameters C0
    C4 (V\- net016) capacitor c=4*C0
    C7 (V\- net1) capacitor c=C0
    C6 (V\- net014) capacitor c=C0
    C8 (VOUT V\-) capacitor c=C0
    C5 (V\- net015) capacitor c=2*C0
    I30 (VOUT VSS CLK1 VDD VSS) mux_switches
    I29 (V\- VSS CLK1 VDD VSS) mux_switches
    I5 (G\<2\> CLK1 X\<2\> VDD VSS) AND2HDX0_dupe
    I4 (G\<1\> CLK1 X\<1\> VDD VSS) AND2HDX0_dupe
    I3 (G\<0\> CLK1 X\<0\> VDD VSS) AND2HDX0_dupe
    I12 (CLK2 GB\<2\> CLK2_GATE\<2\> VDD VSS) OR2HDX0_dupe
    I11 (CLK2 GB\<1\> CLK2_GATE\<1\> VDD VSS) OR2HDX0_dupe
    I6 (CLK2 GB\<0\> CLK2_GATE\<0\> VDD VSS) OR2HDX0_dupe
    I13 (G\<2\> GB\<2\> VDD VSS) invr_dupe GT_PDW=420n GT_PDL=180.00n sx=4.8e-07 lc=2.7e-07 GT_PUW=720n GT_PUL=180.00n
    I9 (G\<0\> GB\<0\> VDD VSS) invr_dupe GT_PDW=420n GT_PDL=180.00n sx=4.8e-07 lc=2.7e-07 GT_PUW=720n GT_PUL=180.00n
    I10 (G\<1\> GB\<1\> VDD VSS) invr_dupe GT_PDW=420n GT_PDL=180.00n sx=4.8e-07 lc=2.7e-07 GT_PUW=720n GT_PUL=180.00n
    I18 (VSS V\- VDD VOUT VSS) final_project_schematics_2_stage_folded_schematic
    I17 (VDD net4 VSS net5 VSS) opamp_mockup Rout=0
    I25 (net015 VIN X\<1\> VDD VSS) pga_switches
    I22 (VSS net016 CLK2_GATE\<2\> VDD VSS) pga_switches
    I26 (net016 VIN X\<2\> VDD VSS) pga_switches
    I21 (VSS net015 CLK2_GATE\<1\> VDD VSS) pga_switches
    I24 (net014 VIN X\<0\> VDD VSS) pga_switches
    I20 (VSS net014 CLK2_GATE\<0\> VDD VSS) pga_switches
    I23 (net1 VIN CLK1 VDD VSS) pga_switches
    I19 (VSS net1 CLK2 VDD VSS) pga_switches
ends PGA_mockup

// final_project_schematics/mux_mockup_non_ideal/schematic
subckt mux_mockup_non_ideal IN\<3\> IN\<2\> IN\<1\> IN\<0\> OUT S\<1\> S\<0\> VDD VSS
    I3 (IN\<2\> net07 Sb\<0\> VDD VSS) mux_switches
    I2 (IN\<3\> net07 S\<0\> VDD VSS) mux_switches
    I4 (IN\<1\> net6 S\<0\> VDD VSS) mux_switches
    I5 (IN\<0\> net6 Sb\<0\> VDD VSS) mux_switches
    I6 (net07 OUT S\<1\> VDD VSS) mux_switches
    I7 (net6 OUT Sb\<1\> VDD VSS) mux_switches
    I1 (S\<1\> Sb\<1\> VDD VSS) invr_dupe GT_PDW=420n GT_PDL=180.00n sx=4.8e-07 lc=2.7e-07 GT_PUW=720n GT_PUL=180.00n
    I0 (S\<0\> Sb\<0\> VDD VSS) invr_dupe GT_PDW=420n GT_PDL=180.00n sx=4.8e-07 lc=2.7e-07 GT_PUW=720n GT_PUL=180.00n
ends mux_mockup_non_ideal

// EE_140_240A_Final_Project/Final_5OTA_LDO/schematic
subckt Final_5OTA_LDO VDD VSS Vin\+ Vin\- Vout
    NM1 (net7 VBNR VSS VSS) nfet_01v8 w=(2.5u) l=1.4u m=(1)*(1)
    NM5 (VBNR VBNR VSS VSS) nfet_g5v0d10v5 w=(5u) l=500n m=(1)*(1)
    NM3 (VBP VBNR VSS VSS) nfet_g5v0d10v5 w=(5u) l=500n m=(1)*(1)
    NM2 (Vout Vin\- net7 net7) nfet_g5v0d10v5 w=(750n) l=1.4u m=(1)*(1)
    NM0 (net4 Vin\+ net7 net7) nfet_g5v0d10v5 w=(750n) l=1.4u m=(1)*(1)
    PM3 (VBNR VBP net1 net1) pfet_g5v0d10v5 w=(25u) l=500n m=(1)*(1)
    PM2 (VBP VBP VDD VDD) pfet_g5v0d10v5 w=(5u) l=500n m=(1)*(1)
    PM1 (Vout net4 VDD VDD) pfet_g5v0d10v5 w=(2.3u) l=1.4u m=(1)*(1)
    PM0 (net4 net4 VDD VDD) pfet_g5v0d10v5 w=(2.3u) l=1.4u m=(1)*(1)
    R0 (VDD net1) resistor r=20K
ends Final_5OTA_LDO

// EE_140_240A_Final_Project/Final-BGR/schematic
subckt _sub1 VBG VBN VDD VPTAT VSS
    R5 (VPTAT VSS) resistor r=12K
    R2 (V\+ net9) resistor r=12.15k
    R1 (VBG V\+) resistor r=18526.32
    R0 (VDD net3) resistor r=20K
    NM14 (net1 VBP VSS VSS) nfet_g5v0d10v5 w=(750n) l=500n m=(1)*(1)
    NM16 (net9 net9 VSS VSS) nfet_g5v0d10v5 w=(5u) l=500n m=(10)*(1)
    NM7 (net6 VBNR VSS VSS) nfet_g5v0d10v5 w=(5u) l=500n m=(1)*(1)
    NM15 (V\- V\- VSS VSS) nfet_g5v0d10v5 w=(5u) l=500n m=(1)*(1)
    NM3 (Vout V\- net6 net6) nfet_g5v0d10v5 w=(5u) l=500n m=(1)*(1)
    NM4 (net4 V\+ net6 net6) nfet_g5v0d10v5 w=(5u) l=500n m=(1)*(1)
    NM5 (VBNR VBNR VSS VSS) nfet_g5v0d10v5 w=(5u) l=500n m=(1)*(1)
    NM0 (VBP VBNR VSS VSS) nfet_g5v0d10v5 w=(5u) l=500n m=(1)*(1)
    I18 (net17 net18 net15 net14 net16) Final_5OTA_LDO
    PM10 (VBNR net1 VDD VDD) pfet_g5v0d10v5 w=(750n) l=500n m=(1)*(1)
    PM9 (net1 VBP VDD VDD) pfet_g5v0d10v5 w=(750n) l=500n m=(1)*(1)
    PM2 (net4 net4 VDD VDD) pfet_g5v0d10v5 w=(5u) l=500n m=(1)*(1)
    PM6 (VPTAT Vout VDD VDD) pfet_g5v0d10v5 w=(5u) l=500n m=(1)*(1)
    PM3 (Vout net4 VDD VDD) pfet_g5v0d10v5 w=(5u) l=500n m=(1)*(1)
    PM4 (V\- Vout VDD VDD) pfet_g5v0d10v5 w=(1u) l=500n m=(1)*(1)
    PM5 (VBG Vout VDD VDD) pfet_g5v0d10v5 w=(1u) l=500n m=(1)*(1)
    PM1 (VBNR VBP net3 net3) pfet_g5v0d10v5 w=(20u) l=500n m=(1)*(1)
    PM0 (VBP VBP VDD VDD) pfet_g5v0d10v5 w=(5u) l=500n m=(1)*(1)
ends _sub1

// EE_140_240A_Final_Project/BGR_mockup/schematic
subckt BGR_mockup VBAT VBG VDDA VPTAT VREF_ADC VSS
    V0 (VREF_ADC VSS) vsource dc=1 type=dc
    I9 (VBG net4 VBAT VPTAT VSS) _sub1
ends BGR_mockup

// final_project_schematics/5t_ota/schematic
subckt final_project_schematics_5t_ota_schematic V\+ V\- VBN VDD VOUT VSS
    NM2 (VOUT V\- net1 net1) nfet_g5v0d10v5 w=(4u) l=500n m=(1)*(1)
    NM1 (net1 VBN VSS VSS) nfet_g5v0d10v5 w=(8u) l=1u m=(1)*(1)
    NM0 (net2 V\+ net1 net1) nfet_g5v0d10v5 w=(4u) l=500n m=(1)*(1)
    PM1 (net2 net2 VDD VDD) pfet_g5v0d10v5 w=(11u) l=500n m=(1)*(1)
    PM0 (VOUT net2 VDD VDD) pfet_g5v0d10v5 w=(11u) l=500n m=(1)*(1)
ends final_project_schematics_5t_ota_schematic

// EE_140_240A_Final_Project/Final_LDO_VDDDA/schematic
subckt Final_LDO_VDDDA VBAT VDD VREF VSS
    PM1 (VDD net7 VBAT VBAT) pfet_g5v0d10v5 w=(50u) l=500n m=(100)*(1)
    R1 (net2 VSS) resistor r=28k
    R6 (VDD net2) resistor r=20.35k
    I49 (VBAT VSS VREF net1 net1) Final_5OTA_LDO
    I47 (net2 net1 net1 VBAT net7 VSS) final_project_schematics_5t_ota_schematic
ends Final_LDO_VDDDA

// EE_140_240A_Final_Project/AREG_mockup/schematic
subckt AREG_mockup VBAT VDDA VREF VSS
    E5 (net3 net2 net5 net4) vcvs gain=10 type=vcvs min=0 max=1.8
    C2 (VDDA VSS) capacitor c=1n
    I6 (VBAT VDDA VREF VSS) Final_LDO_VDDDA
ends AREG_mockup

// EE_140_240A_Final_Project/Final_LDO/schematic
subckt Final_LDO VBAT VDD VREF VSS
    PM0 (VDD net1 VBAT VBAT) pfet_g5v0d10v5 w=(50u) l=500n m=(20)*(1)
    R1 (net3 VSS) resistor r=65.5k
    R6 (VDD net3) resistor r=40.7k
    C6 (VDD VSS) capacitor c=1n ic=0
    I40 (net5 net4 VBAT net2 VSS) _sub1
    I28 (VBAT VSS net3 net5 net1) Final_5OTA_LDO
ends Final_LDO

// EE_140_240A_Final_Project/DREG_mockup/schematic
subckt DREG_mockup VBAT VDDD VREF VSS
    I8 (VBAT VDDD VREF VSS) Final_LDO
ends DREG_mockup

// EE_140_240A_Final_Project/VBATDIV4_mockup/schematic
subckt VBATDIV4_mockup VBAT VBATDIV4 VSS
    E1 (net2 net1 net4 net3) vcvs gain=1/4 type=vcvs
    R1 (VBATDIV4 VSS) resistor r=10K
    R0 (VBAT VBATDIV4) resistor r=30K
ends VBATDIV4_mockup

// EE_140_240A_Final_Project/switch2_mockup_non_ideal/schematic
subckt switch2_mockup_non_ideal A B OUT PHIA PHIB VDD VSS
    NM3 (not_PHIA PHIA VSS VSS) nfet_01v8 w=(420n) l=150n m=(1)*(1)
    NM2 (not_PHIB PHIB VSS VSS) nfet_01v8 w=(420n) l=150n m=(1)*(1)
    NM1 (OUT PHIB B VSS) nfet_01v8 w=(420n) l=150n m=(4)*(1)
    NM0 (OUT PHIA A VSS) nfet_01v8 w=(420n) l=150n m=(4)*(1)
    PM3 (not_PHIA PHIA VDD VDD) pfet_01v8 w=(550n) l=150n m=(1)*(1)
    PM2 (not_PHIB PHIB VDD VDD) pfet_01v8 w=(550n) l=150n m=(1)*(1)
    PM1 (OUT not_PHIB B VDD) pfet_01v8 w=(550n) l=150n m=(16)*(1)
    PM0 (OUT not_PHIA A VDD) pfet_01v8 w=(550n) l=150n m=(16)*(1)
ends switch2_mockup_non_ideal

// EE_140_240A_Final_Project/capdac_mockup/schematic
subckt capdac_mockup D\<7\> D\<6\> D\<5\> D\<4\> D\<3\> D\<2\> D\<1\> D\<0\> LOAD VDAC VDD VIN VREF VSS COMPARE
parameters C0
    C8 (VDAC BOT\<7\>) capacitor c=C0 m=128
    C7 (VDAC BOT\<6\>) capacitor c=C0 m=64
    C6 (VDAC BOT\<5\>) capacitor c=C0 m=32
    C5 (VDAC BOT\<4\>) capacitor c=C0 m=16
    C4 (VDAC BOT\<3\>) capacitor c=C0 m=8
    C3 (VDAC BOT\<2\>) capacitor c=C0 m=4
    C2 (VDAC BOT\<1\>) capacitor c=C0 m=2
    C1 (VDAC BOT\<0\>) capacitor c=C0 m=1
    C0 (VDAC BOTX) capacitor c=C0 m=1
    I48 (VREF VDAC LOAD VDD VSS) mux_switches
    I17 (net031 D_SHIFT\<7\> VREF_SHIFT VSS) invr_dupe GT_PDW=420n GT_PDL=180.00n sx=4.8e-07 lc=2.7e-07 GT_PUW=720n GT_PUL=180.00n
    I16 (net032 D_SHIFT\<6\> VREF_SHIFT VSS) invr_dupe GT_PDW=420n GT_PDL=180.00n sx=4.8e-07 lc=2.7e-07 GT_PUW=720n GT_PUL=180.00n
    I15 (D\<7\> net031 VREF_SHIFT VSS) invr_dupe GT_PDW=420n GT_PDL=180.00n sx=4.8e-07 lc=2.7e-07 GT_PUW=720n GT_PUL=180.00n
    I14 (D\<6\> net032 VREF_SHIFT VSS) invr_dupe GT_PDW=420n GT_PDL=180.00n sx=4.8e-07 lc=2.7e-07 GT_PUW=720n GT_PUL=180.00n
    I13 (net033 D_SHIFT\<5\> VREF_SHIFT VSS) invr_dupe GT_PDW=420n GT_PDL=180.00n sx=4.8e-07 lc=2.7e-07 GT_PUW=720n GT_PUL=180.00n
    I12 (net034 D_SHIFT\<4\> VREF_SHIFT VSS) invr_dupe GT_PDW=420n GT_PDL=180.00n sx=4.8e-07 lc=2.7e-07 GT_PUW=720n GT_PUL=180.00n
    I11 (D\<5\> net033 VREF_SHIFT VSS) invr_dupe GT_PDW=420n GT_PDL=180.00n sx=4.8e-07 lc=2.7e-07 GT_PUW=720n GT_PUL=180.00n
    I10 (D\<4\> net034 VREF_SHIFT VSS) invr_dupe GT_PDW=420n GT_PDL=180.00n sx=4.8e-07 lc=2.7e-07 GT_PUW=720n GT_PUL=180.00n
    I9 (net035 D_SHIFT\<3\> VREF_SHIFT VSS) invr_dupe GT_PDW=420n GT_PDL=180.00n sx=4.8e-07 lc=2.7e-07 GT_PUW=720n GT_PUL=180.00n
    I8 (net036 D_SHIFT\<2\> VREF_SHIFT VSS) invr_dupe GT_PDW=420n GT_PDL=180.00n sx=4.8e-07 lc=2.7e-07 GT_PUW=720n GT_PUL=180.00n
    I7 (D\<3\> net035 VREF_SHIFT VSS) invr_dupe GT_PDW=420n GT_PDL=180.00n sx=4.8e-07 lc=2.7e-07 GT_PUW=720n GT_PUL=180.00n
    I6 (D\<2\> net036 VREF_SHIFT VSS) invr_dupe GT_PDW=420n GT_PDL=180.00n sx=4.8e-07 lc=2.7e-07 GT_PUW=720n GT_PUL=180.00n
    I5 (net07 D_SHIFT\<1\> VREF_SHIFT VSS) invr_dupe GT_PDW=420n GT_PDL=180.00n sx=4.8e-07 lc=2.7e-07 GT_PUW=720n GT_PUL=180.00n
    I4 (net08 D_SHIFT\<0\> VREF_SHIFT VSS) invr_dupe GT_PDW=420n GT_PDL=180.00n sx=4.8e-07 lc=2.7e-07 GT_PUW=720n GT_PUL=180.00n
    I3 (D\<1\> net07 VREF_SHIFT VSS) invr_dupe GT_PDW=420n GT_PDL=180.00n sx=4.8e-07 lc=2.7e-07 GT_PUW=720n GT_PUL=180.00n
    I2 (D\<0\> net08 VREF_SHIFT VSS) invr_dupe GT_PDW=420n GT_PDL=180.00n sx=4.8e-07 lc=2.7e-07 GT_PUW=720n GT_PUL=180.00n
    E8 (D_BUF\<7\> VSS D_SHIFT\<7\> VSS) vcvs gain=1.0
    E7 (D_BUF\<6\> VSS D_SHIFT\<6\> VSS) vcvs gain=1.0
    E6 (D_BUF\<5\> VSS D_SHIFT\<5\> VSS) vcvs gain=1.0
    E5 (D_BUF\<4\> VSS D_SHIFT\<4\> VSS) vcvs gain=1.0
    E4 (D_BUF\<3\> VSS D_SHIFT\<3\> VSS) vcvs gain=1.0
    E3 (D_BUF\<2\> VSS D_SHIFT\<2\> VSS) vcvs gain=1.0
    E2 (D_BUF\<1\> VSS D_SHIFT\<1\> VSS) vcvs gain=1.0
    E1 (D_BUF\<0\> VSS D_SHIFT\<0\> VSS) vcvs gain=1.0
    E0 (VREF_SHIFT VSS VREF VSS) vcvs gain=1.0 type=vcvs
    I42 (VIN D_BUF\<7\> BOT\<7\> LOAD COMPARE VDD VSS) switch2_mockup_non_ideal
    I40 (VIN D_BUF\<0\> BOT\<0\> LOAD COMPARE VDD VSS) switch2_mockup_non_ideal
    I41 (VIN D_BUF\<1\> BOT\<1\> LOAD COMPARE VDD VSS) switch2_mockup_non_ideal
    I43 (VIN D_BUF\<6\> BOT\<6\> LOAD COMPARE VDD VSS) switch2_mockup_non_ideal
    I44 (VIN D_BUF\<5\> BOT\<5\> LOAD COMPARE VDD VSS) switch2_mockup_non_ideal
    I45 (VIN D_BUF\<4\> BOT\<4\> LOAD COMPARE VDD VSS) switch2_mockup_non_ideal
    I46 (VIN D_BUF\<3\> BOT\<3\> LOAD COMPARE VDD VSS) switch2_mockup_non_ideal
    I47 (VIN D_BUF\<2\> BOT\<2\> LOAD COMPARE VDD VSS) switch2_mockup_non_ideal
    I39 (VIN VSS BOTX LOAD COMPARE VDD VSS) switch2_mockup_non_ideal
ends capdac_mockup

// final_project_schematics/strongarm/schematic
subckt strongarm CLK VDAC VDD VOUT_BIGGER VOUT_SMALLER VSS V_REF
    PM6 (Y X VDD VDD) pfet_01v8 w=(600n) l=300n m=(1)*(1)
    PM3 (Y CLK VDD VDD) pfet_01v8 w=(600n) l=300n m=(1)*(1)
    PM2 (net3 CLK VDD VDD) pfet_01v8 w=(600n) l=300n m=(1)*(1)
    PM1 (X CLK VDD VDD) pfet_01v8 w=(600n) l=300n m=(1)*(1)
    PM0 (net1 CLK VDD VDD) pfet_01v8 w=(600n) l=300n m=(1)*(1)
    NM4 (net5 CLK VSS VSS) nfet_01v8 w=(600n) l=300n m=(1)*(1)
    NM3 (net3 VDAC net5 net5) nfet_01v8 w=(420n) l=300n m=(1)*(1)
    NM2 (net1 V_REF net5 net5) nfet_01v8 w=(420n) l=300n m=(1)*(1)
    NM1 (X Y net1 net1) nfet_01v8 w=(600n) l=300n m=(1)*(1)
    NM0 (Y X net3 net3) nfet_01v8 w=(600n) l=300n m=(1)*(1)
    NM5 (VDD Y X VDD) nfet_01v8 w=(600n) l=300n m=(1)*(1)
    I3 (net4 VOUT_BIGGER VDD VSS) invr_dupe GT_PDW=420n GT_PDL=180.00n sx=4.8e-07 lc=2.7e-07 GT_PUW=720n GT_PUL=180.00n
    I2 (Y net4 VDD VSS) invr_dupe GT_PDW=420n GT_PDL=180.00n sx=4.8e-07 lc=2.7e-07 GT_PUW=720n GT_PUL=180.00n
    I1 (net2 VOUT_SMALLER VDD VSS) invr_dupe GT_PDW=420n GT_PDL=180.00n sx=4.8e-07 lc=2.7e-07 GT_PUW=720n GT_PUL=180.00n
    I0 (X net2 VDD VSS) invr_dupe GT_PDW=420n GT_PDL=180.00n sx=4.8e-07 lc=2.7e-07 GT_PUW=720n GT_PUL=180.00n
ends strongarm

// EE_140_240A_Final_Project/ADC_mockup/schematic
subckt ADC_mockup CLK COMP_OUT D\<7\> D\<6\> D\<5\> D\<4\> D\<3\> D\<2\> D\<1\> D\<0\> VDD VIN VREF VSS COMPARE LOAD
    X_CAPDAC (D\<7\> D\<6\> D\<5\> D\<4\> D\<3\> D\<2\> D\<1\> D\<0\> LOAD VDAC VDD VIN VREF VSS COMPARE) capdac_mockup C0=10f
    I6 (net8 net6 net5 net7 net9) opamp_mockup Rout=100
    I9 (CLK VDAC VDD COMP_OUT net1 VSS VREF) strongarm
ends ADC_mockup

// EE_140_240A_Final_Project/EE_140_240A_Sp25_Student_Submission/schematic
subckt EE_140_240A_Sp25_Student_Submission CLK_ADC CLK_PGA1 CLK_PGA2 COMP D\<7\> D\<6\> D\<5\> D\<4\> D\<3\> D\<2\> D\<1\> D\<0\> EXT_IN\<0\> EXT_IN\<1\> G\<2\> G\<1\> G\<0\> S\<1\> S\<0\> VBAT VBATDIV4 VDDA VDDD VPTAT VSS
    X_PGA (CLK_PGA1 CLK_PGA2 G\<2\> G\<1\> G\<0\> VDDA MUX_OUT PGA_OUT VSS) PGA_mockup C0=2p
    I8 (VPTAT VBATDIV4 EXT_IN\<1\> EXT_IN\<0\> MUX_OUT S\<1\> S\<0\> VDDA VSS) mux_mockup_non_ideal
    X_BGR (VBAT VREF_REG VDDA VPTAT VREF_ADC VSS) BGR_mockup
    X_AREG (VBAT VDDA VREF_REG VSS) AREG_mockup
    X_DREG (VBAT VDDD VREF_REG VSS) DREG_mockup
    X_DIV4 (VBAT VBATDIV4 VSS) VBATDIV4_mockup
    X_ADC (CLK_ADC COMP D\<7\> D\<6\> D\<5\> D\<4\> D\<3\> D\<2\> D\<1\> D\<0\> VDDA PGA_OUT VREF_ADC VSS CLK_PGA1 CLK_PGA2) ADC_mockup
ends EE_140_240A_Sp25_Student_Submission

// EE_140_240A_Final_Project/NA2HDX0_dupe/schematic
subckt NA2HDX0_dupe A B Q VDD VSS
    MN1 (Q A net44 VSS) ne w=420.0n l=180.0n m=(1)*(1)
    MN2 (net44 B VSS VSS) ne w=420.0n l=180.0n m=(1)*(1)
    MP1 (Q A VDD VDD) pe w=720.0n l=180.0n m=(1)*(1)
    MP2 (Q B VDD VDD) pe w=720.0n l=180.0n m=(1)*(1)
ends NA2HDX0_dupe

// EE_140_240A_Final_Project/clk_nonoverlapping/schematic
subckt clk_nonoverlapping CLK_IN PHI1 PHI2 VDD VSS
    I7 (net09 net5 net1 VDD VSS) NA2HDX0_dupe
    I0 (CLK_IN net08 net4 VDD VSS) NA2HDX0_dupe
    C5 (net08 VSS) capacitor c=100f
    C4 (net09 VSS) capacitor c=100f
    C3 (net3 VSS) capacitor c=100f
    C2 (net4 VSS) capacitor c=100f
    C1 (net2 VSS) capacitor c=100f
    C0 (net1 VSS) capacitor c=100f
    I9 (net08 PHI2 VDD VSS) invr_dupe GT_PDW=420n GT_PDL=180.00n sx=4.8e-07 lc=2.7e-07 GT_PUW=720n GT_PUL=180.00n
    I8 (net09 PHI1 VDD VSS) invr_dupe GT_PDW=420n GT_PDL=180.00n sx=4.8e-07 lc=2.7e-07 GT_PUW=720n GT_PUL=180.00n
    I6 (CLK_IN net5 VDD VSS) invr_dupe GT_PDW=420n GT_PDL=180.00n sx=4.8e-07 lc=2.7e-07 GT_PUW=720n GT_PUL=180.00n
    I5 (net3 net09 VDD VSS) invr_dupe GT_PDW=420n GT_PDL=180.00n sx=4.8e-07 lc=2.7e-07 GT_PUW=720n GT_PUL=180.00n
    I4 (net2 net08 VDD VSS) invr_dupe GT_PDW=420n GT_PDL=180.00n sx=4.8e-07 lc=2.7e-07 GT_PUW=720n GT_PUL=180.00n
    I3 (net1 net2 VDD VSS) invr_dupe GT_PDW=420n GT_PDL=180.00n sx=4.8e-07 lc=2.7e-07 GT_PUW=720n GT_PUL=180.00n
    I2 (net4 net3 VDD VSS) invr_dupe GT_PDW=420n GT_PDL=180.00n sx=4.8e-07 lc=2.7e-07 GT_PUW=720n GT_PUL=180.00n
ends clk_nonoverlapping

// EE_140_240A_Final_Project/DFRRSHDX0_dupe/schematic
subckt DFRRSHDX0_dupe C D Q QN RN SN VDD VSS
    MN10 (SQIB CI net268 VSS) ne w=420.0n l=180.0n m=(1)*(1)
    MN14 (SQIB CIB net266 VSS) ne w=420.0n l=180.0n m=(1)*(1)
    MN2 (MQIB CIB net271 VSS) ne w=420.0n l=180.0n m=(1)*(1)
    MN6 (MQIB CI net270 VSS) ne w=420.0n l=180.0n m=(1)*(1)
    MN13 (net266 SQI net265 VSS) ne w=420.0n l=180.0n m=(1)*(1)
    MN7 (MQI MQIB net269 VSS) ne w=505.00n l=180.0n m=(1)*(1)
    MN15 (SQI SQIB net264 VSS) ne w=890.0n l=180.0n m=(1)*(1)
    MN9 (net268 MQI net267 VSS) ne w=420.0n l=180.0n m=(1)*(1)
    MN1 (net271 D net273 VSS) ne w=420.0n l=180.0n m=(1)*(1)
    MN5 (net270 MQI net272 VSS) ne w=420.0n l=180.0n m=(1)*(1)
    MN11 (net267 RN VSS VSS) ne w=420.0n l=180.0n m=(1)*(1)
    MN16 (net264 SN VSS VSS) ne w=890.0n l=180.0n m=(1)*(1)
    MN12 (net265 RN VSS VSS) ne w=420.0n l=180.0n m=(1)*(1)
    MN8 (net269 SN VSS VSS) ne w=505.00n l=180.0n m=(1)*(1)
    MN3 (net273 RN VSS VSS) ne w=420.0n l=180.0n m=(1)*(1)
    MN4 (net272 RN VSS VSS) ne w=420.0n l=180.0n m=(1)*(1)
    MP3 (MQIB RN VDD VDD) pe w=955.00n l=180.0n m=(1)*(1)
    MP14 (SQI SN VDD VDD) pe w=925.00n l=180.0n m=(1)*(1)
    MP10 (SQIB RN VDD VDD) pe w=505.00n l=180.0n m=(1)*(1)
    MP6 (MQI MQIB VDD VDD) pe w=850.0n l=180.0n m=(1)*(1)
    MP9 (net261 MQI VDD VDD) pe w=715.00n l=180.0n m=(1)*(1)
    MP7 (MQI SN VDD VDD) pe w=850.0n l=180.0n m=(1)*(1)
    MP13 (SQI SQIB VDD VDD) pe w=925.00n l=180.0n m=(1)*(1)
    MP12 (net260 SQI VDD VDD) pe w=420.0n l=180.0n m=(1)*(1)
    MP5 (net262 MQI VDD VDD) pe w=420.0n l=180.0n m=(1)*(1)
    MP2 (net263 D VDD VDD) pe w=705.00n l=180.0n m=(1)*(1)
    MP11 (SQIB CI net260 VDD) pe w=420.0n l=180.0n m=(1)*(1)
    MP4 (MQIB CIB net262 VDD) pe w=420.0n l=180.0n m=(1)*(1)
    MP8 (SQIB CIB net261 VDD) pe w=715.00n l=180.0n m=(1)*(1)
    MP1 (MQIB CI net263 VDD) pe w=705.00n l=180.0n m=(1)*(1)
    I0 (C CIB VDD VSS) invr_dupe GT_PDW=420.0n GT_PDL=180.00n sx=4.8e-07 lc=2.7e-07 GT_PUW=720.00n GT_PUL=180.00n
    I2 (SQI QN VDD VSS) invr_dupe GT_PDW=420.0n GT_PDL=180.00n sx=4.8e-07 lc=2.7e-07 GT_PUW=720.00n GT_PUL=180.00n
    I1 (CIB CI VDD VSS) invr_dupe GT_PDW=420.0n GT_PDL=180.00n sx=4.8e-07 lc=2.7e-07 GT_PUW=720.00n GT_PUL=180.00n
    I3 (SQIB Q VDD VSS) invr_dupe GT_PDW=420.0n GT_PDL=180.00n sx=4.8e-07 lc=2.7e-07 GT_PUW=720.00n GT_PUL=180.00n
ends DFRRSHDX0_dupe

// EE_140_240A_Final_Project/SAR_DFF/schematic
subckt SAR_DFF CLK COMP D\<7\> D\<6\> D\<5\> D\<4\> D\<3\> D\<2\> D\<1\> D\<0\> RESETB DONE VDD VSS
    I18 (VSS VSS DONE net019 RESETB net010 VDD VSS) DFRRSHDX0_dupe
    I17 (DONE COMP D\<0\> net067 RESETB net014 VDD VSS) DFRRSHDX0_dupe
    I16 (D\<0\> COMP D\<1\> net025 RESETB net018 VDD VSS) DFRRSHDX0_dupe
    I15 (D\<1\> COMP D\<2\> net029 RESETB net022 VDD VSS) DFRRSHDX0_dupe
    I14 (D\<2\> COMP D\<3\> net033 RESETB net026 VDD VSS) DFRRSHDX0_dupe
    I13 (D\<3\> COMP D\<4\> net065 RESETB net030 VDD VSS) DFRRSHDX0_dupe
    I12 (D\<4\> COMP D\<5\> net043 RESETB net034 VDD VSS) DFRRSHDX0_dupe
    I11 (D\<5\> COMP D\<6\> net048 RESETB net038 VDD VSS) DFRRSHDX0_dupe
    I10 (D\<6\> COMP D\<7\> net053 RESETB net2 VDD VSS) DFRRSHDX0_dupe
    I8 (CLK X\<0\> net09 net010 RESETB VDD VDD VSS) DFRRSHDX0_dupe
    I7 (CLK X\<1\> X\<0\> net014 RESETB VDD VDD VSS) DFRRSHDX0_dupe
    I6 (CLK X\<2\> X\<1\> net018 RESETB VDD VDD VSS) DFRRSHDX0_dupe
    I5 (CLK X\<3\> X\<2\> net022 RESETB VDD VDD VSS) DFRRSHDX0_dupe
    I4 (CLK X\<4\> X\<3\> net026 RESETB VDD VDD VSS) DFRRSHDX0_dupe
    I3 (CLK X\<5\> X\<4\> net030 RESETB VDD VDD VSS) DFRRSHDX0_dupe
    I2 (CLK X\<6\> X\<5\> net034 RESETB VDD VDD VSS) DFRRSHDX0_dupe
    I1 (CLK X\<7\> X\<6\> net038 RESETB VDD VDD VSS) DFRRSHDX0_dupe
    I0 (CLK VSS X\<7\> net2 VDD RESETB VDD VSS) DFRRSHDX0_dupe
ends SAR_DFF

// EE_140_240A_Final_Project/mux2_mockup/schematic
subckt mux2_mockup IN\<1\> IN\<0\> S VDD VOUT VSS
    W1 (IN\<1\> VOUT S VSS) relay vt1=100m vt2=600m ropen=1T rclosed=10
    W0 (IN\<0\> VOUT Sb VSS) relay vt1=100m vt2=600m ropen=1T rclosed=10
    I0 (S Sb VDD VSS) invr_dupe GT_PDW=420n GT_PDL=180.00n sx=4.8e-07 lc=2.7e-07 GT_PUW=720n GT_PUL=180.00n
ends mux2_mockup

// EE_140_240A_Final_Project/mux_mockup/schematic
subckt mux_mockup IN\<3\> IN\<2\> IN\<1\> IN\<0\> OUT S\<1\> S\<0\> VDD VSS
    W2 (IN\<2\> net1 Sb\<0\> VSS) relay vt1=100m vt2=600m ropen=1T rclosed=10
    W4 (net2 OUT Sb\<1\> VSS) relay vt1=100m vt2=600m ropen=1T rclosed=10
    W3 (IN\<3\> net1 S\<0\> VSS) relay vt1=100m vt2=600m ropen=1T rclosed=10
    W5 (net1 OUT S\<1\> VSS) relay vt1=100m vt2=600m ropen=1T rclosed=10
    W0 (IN\<0\> net2 Sb\<0\> VSS) relay vt1=100m vt2=600m ropen=1T rclosed=10
    W1 (IN\<1\> net2 S\<0\> VSS) relay vt1=100m vt2=600m ropen=1T rclosed=10
    I1 (S\<1\> Sb\<1\> VDD VSS) invr_dupe GT_PDW=420n GT_PDL=180.00n sx=4.8e-07 lc=2.7e-07 GT_PUW=720n GT_PUL=180.00n
    I0 (S\<0\> Sb\<0\> VDD VSS) invr_dupe GT_PDW=420n GT_PDL=180.00n sx=4.8e-07 lc=2.7e-07 GT_PUW=720n GT_PUL=180.00n
ends mux_mockup

// EE_140_240A_Final_Project/XNOR_gate/schematic
subckt XNOR_gate A B OUT VDD VSS
    I2 (A B net5 VDD VSS) AND2HDX0_dupe
    I1 (net3 net2 net4 VDD VSS) AND2HDX0_dupe
    I4 (B net2 VDD VSS) invr_dupe GT_PDW=420n GT_PDL=180.00n sx=4.8e-07 lc=2.7e-07 GT_PUW=720n GT_PUL=180.00n
    I3 (A net3 VDD VSS) invr_dupe GT_PDW=420n GT_PDL=180.00n sx=4.8e-07 lc=2.7e-07 GT_PUW=720n GT_PUL=180.00n
    I0 (net4 net5 OUT VDD VSS) OR2HDX0_dupe
ends XNOR_gate

// EE_140_240A_Final_Project/SAR_FSM_HW/schematic
subckt SAR_FSM_HW VDD VSS adc_convert adc_done adc_resetb clk clk_dff clk_pga run_conversion
    I28 (VSS net11 net12 VDD next_state\<1\> VSS) mux2_mockup
    I6 (VDD VSS M_SEL_CONV\<1\> VDD adc_convert VSS) mux2_mockup
    I4 (VSS VDD net12 VDD clk_pga VSS) mux2_mockup
    I3 (VSS VDD net12 VDD adc_resetb VSS) mux2_mockup
    I2 (VDD net14 net12 VDD next_state\<0\> VSS) mux2_mockup
    I32 (VSS VSS net15 net13 next_state\<1\> M_SEL_CONV\<1\> M_SEL_CONV\<0\> VDD VSS) mux_mockup
    I25 (VDD VSS net10 net9 next_state\<1\> M_SEL_IDLE\<1\> M_SEL_IDLE\<0\> VDD VSS) mux_mockup
    I8 (VSS VSS net46 net41 next_state\<0\> M_SEL_IDLE\<1\> M_SEL_IDLE\<0\> VDD VSS) mux_mockup
    I7 (VSS VDD net32 net27 next_state\<0\> M_SEL_CONV\<1\> M_SEL_CONV\<0\> VDD VSS) mux_mockup
    I38 (clk adc_convert clk_dff VDD VSS) AND2HDX0_dupe
    I24 (VDD run_conversion M_SEL_IDLE\<0\> VDD VSS) AND2HDX0_dupe
    I23 (VDD adc_done M_SEL_CONV\<0\> VDD VSS) AND2HDX0_dupe
    I11 (net63 net62 M_SEL_CONV\<1\> VDD VSS) AND2HDX0_dupe
    I10 (net58 net57 net12 VDD VSS) AND2HDX0_dupe
    I9 (net53 net52 M_SEL_IDLE\<1\> VDD VSS) AND2HDX0_dupe
    I17 (S\<0\> VDD net63 VDD VSS) XNOR_gate
    I16 (S\<1\> VSS net62 VDD VSS) XNOR_gate
    I15 (S\<1\> VDD net57 VDD VSS) XNOR_gate
    I14 (S\<0\> VSS net58 VDD VSS) XNOR_gate
    I13 (S\<1\> VSS net52 VDD VSS) XNOR_gate
    I12 (S\<0\> VSS net53 VDD VSS) XNOR_gate
    I36 (clk next_state\<1\> S\<1\> net1 VDD VDD VDD VSS) DFRRSHDX0_dupe
    I0 (clk next_state\<0\> S\<0\> net5 VDD VDD VDD VSS) DFRRSHDX0_dupe
ends SAR_FSM_HW

// EE_140_240A_Final_Project/EE_140_240A_Sp25_DigitalTop/schematic
subckt EE_140_240A_Sp25_DigitalTop CLK CLK_ADC CLK_PGA1 CLK_PGA2 COMP DAC\<7\> DAC\<6\> DAC\<5\> DAC\<4\> DAC\<3\> DAC\<2\> DAC\<1\> DAC\<0\> DONE ENABLE VDD VSS
    X_PGACLKGEN (CLK_PGA CLK_PGA1 CLK_PGA2 VDD VSS) clk_nonoverlapping
    I6 (net12 RESETB_BUF VDD VSS) invr_dupe GT_PDW=420n GT_PDL=180.00n sx=4.8e-07 lc=2.7e-07 GT_PUW=720n GT_PUL=180.00n
    I5 (RESETB net12 VDD VSS) invr_dupe GT_PDW=420n GT_PDL=180.00n sx=4.8e-07 lc=2.7e-07 GT_PUW=720n GT_PUL=180.00n
    X_SAR (CLK_ADC COMP DAC\<7\> DAC\<6\> DAC\<5\> DAC\<4\> DAC\<3\> DAC\<2\> DAC\<1\> DAC\<0\> RESETB_BUF DONE VDD VSS) SAR_DFF
    X_FSM (VDD VSS CONVERT DONE RESETB CLK CLK_ADC CLK_PGA ENABLE) SAR_FSM_HW
ends EE_140_240A_Sp25_DigitalTop

// EE_140_240A_Final_Project/EE_140_240A_Sp25_System/schematic
X_STUDENT (CLK_ADC CLK_PGA1 CLK_PGA2 COMP D\<7\> D\<6\> D\<5\> D\<4\> D\<3\> D\<2\> D\<1\> D\<0\> EXT_IN\<0\> EXT_IN\<1\> G\<2\> G\<1\> G\<0\> S\<1\> S\<0\> VBAT VBATDIV4 VDDA VDDD VPTAT 0) EE_140_240A_Sp25_Student_Submission
V6 (net8 0) vsource type=pulse edgetype=halfsine val0=0 val1=NBAT*VBAT rise=TRISE_BAT
V4 (VDDD_IDEAL 0) vsource type=pulse edgetype=halfsine val0=0 val1=VDDD_IDEAL delay=0 rise=TR_D
V1 (CLK 0) vsource type=pulse edgetype=halfsine val0=0 val1=1.8 period=1/FCLK rise=10n fall=10n width=.5/FCLK
I22 (VDDD 0) isource type=pulse val0=1m val1=5m period=100n delay=10n rise=10n fall=10n width=30n
E12 (B\<3\> 0 D\<3\> V0P5) vcvs gain=2 type=vcvs min=0 max=1
E11 (B\<1\> 0 D\<1\> V0P5) vcvs gain=2 type=vcvs min=0 max=1
E10 (B\<0\> 0 D\<0\> V0P5) vcvs gain=2 type=vcvs min=0 max=1
E9 (B\<2\> 0 D\<2\> V0P5) vcvs gain=2 type=vcvs min=0 max=1
E8 (B\<5\> 0 D\<5\> V0P5) vcvs gain=2 type=vcvs min=0 max=1
E7 (B\<4\> 0 D\<4\> V0P5) vcvs gain=2 type=vcvs min=0 max=1
E6 (B\<6\> 0 D\<6\> V0P5) vcvs gain=2 type=vcvs min=0 max=1
E5 (B\<7\> 0 D\<7\> V0P5) vcvs gain=2 type=vcvs min=0 max=1
E4 (G\<2\> 0 VDDD 0) vcvs gain=G_2
E2 (G\<0\> 0 VDDD 0) vcvs gain=G_0
E3 (G\<1\> 0 VDDD 0) vcvs gain=G_1
E0 (S\<1\> 0 VDDD 0) vcvs gain=S_1 type=vcvs
E1 (S\<0\> 0 VDDD 0) vcvs gain=S_0
R0 (VBAT net8) resistor r=NBAT
C0 (VDDD 0) capacitor c=1n
V0 (EXT_IN\<1\> 0) vsource dc=VIN_1 type=dc
V2 (EXT_IN\<0\> 0) vsource dc=VIN_0 type=dc
V5 (V0P5 0) vsource dc=500.0m type=dc
X_GSI (CLK CLK_ADC CLK_PGA1 CLK_PGA2 COMP D\<7\> D\<6\> D\<5\> D\<4\> D\<3\> D\<2\> D\<1\> D\<0\> DONE VDDA VDDA 0) EE_140_240A_Sp25_DigitalTop
simulatorOptions options temp=37.0 compatible=spice2
tran tran stop=_EXPR_8 errpreset=conservative
save X_STUDENT.PGA_OUT X_STUDENT.MUX_OUT VDDD VDDA EXT_IN\<0\> D\<7\> D\<6\> D\<5\> D\<4\> D\<3\> D\<2\> D\<1\> D\<0\> COMP CLK_PGA2 CLK_ADC B\<7\> B\<6\> B\<5\> B\<4\> B\<3\> B\<2\> B\<1\> B\<0\> X_GSI.RESETB_BUF
saveOptions options save=selected currents=selected
