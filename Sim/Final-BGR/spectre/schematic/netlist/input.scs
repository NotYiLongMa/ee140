// Design: EE_140_240A_Final_Project/Final-BGR
simulator lang=spectre
global 0
parameters TRISE_BAT=100n VBAT=3.2
include "/home/cc/ee140/sp25/class/ee140-aax/cadence_finalproj/sky130_release_0.0.4/libs/sky130_fd_pr_main/../../models/sky130.lib.spice" section=tt

// EE_140_240A_Final_Project/Final_5OTA_LDO/schematic
subckt Final_5OTA_LDO VDD VSS Vin\+ Vin\- Vout
    NM1 (net7 VBNR VSS VSS) nfet_01v8 w=(2.5u) l=1.4u m=(1)*(1)
    NM5 (VBNR VBNR VSS VSS) nfet_g5v0d10v5 w=(5u) l=500n m=(1)*(1)
    NM3 (VBP VBNR VSS VSS) nfet_g5v0d10v5 w=(5u) l=500n m=(1)*(1)
    NM2 (Vout Vin\- net7 net7) nfet_g5v0d10v5 w=(750n) l=1.4u m=(1)*(1)
    NM0 (net4 Vin\+ net7 net7) nfet_g5v0d10v5 w=(750n) l=1.4u m=(1)*(1)
    PM3 (VBNR VBP net1 net1) pfet_g5v0d10v5 w=(25u) l=500n m=(1)*(1)
    PM2 (VBP VBP VDD VDD) pfet_g5v0d10v5 w=(5u) l=500n m=(1)*(1)
    PM1 (Vout net4 VDD VDD) pfet_g5v0d10v5 w=(2.3u) l=1.4u m=(1)*(1)
    PM0 (net4 net4 VDD VDD) pfet_g5v0d10v5 w=(2.3u) l=1.4u m=(1)*(1)
    R0 (VDD net1) resistor r=20K
ends Final_5OTA_LDO

// EE_140_240A_Final_Project/Final-BGR/schematic
R15 (VDD net2) resistor r=2
R5 (VPTAT net5) resistor r=12.15K
R2 (V\+ net9) resistor r=12.15k
R1 (VBG V\+) resistor r=18526.32
R0 (VDD net3) resistor r=20K
NM16 (net9 net9 VSS VSS) nfet_g5v0d10v5 w=(5u) l=500n m=(10)*(1)
NM15 (V\- V\- VSS VSS) nfet_g5v0d10v5 w=(5u) l=500n m=(1)*(1)
NM14 (net1 VBP VSS VSS) nfet_g5v0d10v5 w=(750n) l=500n m=(1)*(1)
NM7 (net6 VBNR VSS VSS) nfet_g5v0d10v5 w=(5u) l=500n m=(1)*(1)
NM3 (Vout V\- net6 net6) nfet_g5v0d10v5 w=(5u) l=500n m=(1)*(1)
NM4 (net4 V\+ net6 net6) nfet_g5v0d10v5 w=(5u) l=500n m=(1)*(1)
NM5 (VBNR VBNR VSS VSS) nfet_g5v0d10v5 w=(5u) l=500n m=(1)*(1)
NM0 (VBP VBNR VSS VSS) nfet_g5v0d10v5 w=(5u) l=500n m=(1)*(1)
I18 (net17 net18 net15 net14 net16) Final_5OTA_LDO
V1 (net2 0) vsource type=pulse edgetype=halfsine val0=0 val1=VBAT rise=TRISE_BAT
V0 (VSS 0) vsource type=dc
PM10 (VBNR net1 VDD VDD) pfet_g5v0d10v5 w=(750n) l=500n m=(1)*(1)
PM9 (net1 VBP VDD VDD) pfet_g5v0d10v5 w=(750n) l=500n m=(1)*(1)
PM2 (net4 net4 VDD VDD) pfet_g5v0d10v5 w=(5u) l=500n m=(1)*(1)
PM6 (VPTAT net8 net7 net7) pfet_g5v0d10v5 w=(5u) l=500n m=(1)*(1)
PM3 (Vout net4 VDD VDD) pfet_g5v0d10v5 w=(5u) l=500n m=(1)*(1)
PM4 (V\- Vout VDD VDD) pfet_g5v0d10v5 w=(1u) l=500n m=(1)*(1)
PM5 (VBG Vout VDD VDD) pfet_g5v0d10v5 w=(1u) l=500n m=(1)*(1)
PM1 (VBNR VBP net3 net3) pfet_g5v0d10v5 w=(20u) l=500n m=(1)*(1)
PM0 (VBP VBP VDD VDD) pfet_g5v0d10v5 w=(5u) l=500n m=(1)*(1)
simulatorOptions options reltol=100e-6 temp=27 homotopy=all limit=delta compatible=spice2
tran tran stop=20u errpreset=conservative
